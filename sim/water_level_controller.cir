* =============================================================================
* GM UNIVERSITY | DEPARTMENT OF ELECTRONICS & COMMUNICATION ENGINEERING
* Course: UE25EC3502 - Linear Integrated Circuits with Practice
* Project: Automatic Water-Level Controller Using Op-Amp and 555 Timer
* NI Multisim / SPICE Compatible Netlist: water_level_controller.cir
* =============================================================================

.title Automatic Water-Level Controller (LM358 + NE555 + BC547 + Relay)

* -----------------------------------------------------------------------------
* DC POWER SUPPLIES
* -----------------------------------------------------------------------------
V_IN 12V_BUS 0 DC 12.0
* IC 7805 Voltage Regulator (Simulated as Regulated 5.0V source with output impedance)
V_REG 5V_BUS 0 DC 5.0
C_IN 12V_BUS 0 0.33u
C_OUT 5V_BUS 0 0.1u

* -----------------------------------------------------------------------------
* REFERENCE VOLTAGE DIVIDER (Unit 2 LIC)
* Generates V_ref_high = 3.33V (2/3 VCC) and V_ref_low = 1.67V (1/3 VCC)
* -----------------------------------------------------------------------------
R1 5V_BUS V_REF_HIGH 10k
R2 V_REF_HIGH V_REF_LOW 10k
R3 V_REF_LOW 0 10k

* -----------------------------------------------------------------------------
* WATER LEVEL SENSING PROBES SIMULATION (Interactive Switches in Multisim)
* S_LOW  simulates Low Level Probe  (Closed = Immersed, Open = Dry)
* S_HIGH simulates High Level Probe (Closed = Immersed, Open = Dry)
* R_W1, R_W2 represent tap water ionic conduction resistance (2.5k ohm)
* R_PD1, R_PD2 are pull-down resistors (100k ohm)
* -----------------------------------------------------------------------------
* Low Level Probe Network:
R_W1 5V_BUS PROBE_LOW_IN 2.5k
R_PD1 PROBE_LOW_IN 0 100k
C_F1 PROBE_LOW_IN 0 0.1u

* High Level Probe Network:
R_W2 5V_BUS PROBE_HIGH_IN 2.5k
R_PD2 PROBE_HIGH_IN 0 100k
C_F2 PROBE_HIGH_IN 0 0.1u

* -----------------------------------------------------------------------------
* SECTION B: LOW-LEVEL SCHMITT TRIGGER COMPARATOR (U1:A - LM358)
* U1:A Pin 1: OUT_LOW, Pin 2: IN- (V_ref_low), Pin 3: IN+ (Schmitt Node)
* -----------------------------------------------------------------------------
R_IN PROBE_LOW_IN SCHMITT_IN 10k
R_FB OUT_LOW SCHMITT_IN 470k

* Subcircuit call or behavioral model for LM358 Comparator 1:
* Inverting input tied to V_REF_LOW (1.67V)
* Non-inverting input tied to SCHMITT_IN
E_COMP1 OUT_LOW 0 VALUE = { IF(V(SCHMITT_IN) > V(V_REF_LOW), 3.8, 0.05) }

* -----------------------------------------------------------------------------
* SECTION C: HIGH-LEVEL COMPARATOR (U1:B - LM358)
* U1:B Pin 7: OUT_HIGH, Pin 6: IN- (V_ref_high = 3.33V), Pin 5: IN+ (PROBE_HIGH_IN)
* -----------------------------------------------------------------------------
E_COMP2 OUT_HIGH 0 VALUE = { IF(V(PROBE_HIGH_IN) > V(V_REF_HIGH), 3.8, 0.05) }

* -----------------------------------------------------------------------------
* SECTION D: NE555 MONOSTABLE & BISTABLE LATCH (U2 - NE555)
* Pin 2: TRIG (Driven by inverted OUT_LOW)
* Pin 4: RESET (Driven by inverted OUT_HIGH)
* Pin 5: CTRL (0.01u to GND)
* Pin 6: THRES, Pin 7: DISCH (Monostable timing: RA = 100k, C1 = 47u)
* Pin 3: OUT_555 (Output to relay driver)
* -----------------------------------------------------------------------------
C_CTRL 555_CTRL 0 0.01u
R_A 5V_BUS 555_TIMING 100k
C_TIMING 555_TIMING 0 47u

* Behavioral RS-Latch logic for 555 output:
* S = (OUT_LOW < 1.0) -> TRIG active low -> SET Output HIGH (Pump ON)
* R = (OUT_HIGH > 3.0) -> High level reached -> RESET Output LOW (Pump OFF)
E_555 OUT_555 0 VALUE = { IF(V(OUT_HIGH) > 2.5, 0.1, IF(V(OUT_LOW) < 1.0, 3.6, 3.6)) }

* -----------------------------------------------------------------------------
* SECTION E: ACTUATOR RELAY DRIVER & DC MOTOR PUMP (BC547 + RELAY)
* Q1 Base driven via R_B (1k)
* D1 1N4007 clamp diode across coil
* Relay coil: 400 ohm, 12V
* -----------------------------------------------------------------------------
R_B OUT_555 BASE_Q1 1k
Q1 RELAY_COIL_NEG BASE_Q1 0 NPN_BC547
.MODEL NPN_BC547 NPN(IS=1.8E-14 BF=250 BR=3 CJC=8P CJE=15P VAF=100)

D_CLAMP RELAY_COIL_NEG 12V_BUS DIODE_1N4007
.MODEL DIODE_1N4007 D(IS=7E-9 RS=0.04 BV=1000 IBV=5U CJO=30P)

* Relay Coil Resistance (Songle SRD-12VDC):
R_COIL 12V_BUS RELAY_COIL_NEG 400

* 12V DC Pump Motor Load (Simulated as 40 ohm DC armature):
R_MOTOR RELAY_NO 0 40
S_RELAY 12V_BUS RELAY_NO RELAY_COIL_NEG 0 SWITCH_RELAY
.MODEL SWITCH_RELAY VSWITCH(RON=0.05 ROFF=1E6 VON=2.0 VOFF=8.0)

* Visual Indicators:
R_LED_PUMP OUT_555 LED_PUMP_NODE 330
D_LED_PUMP LED_PUMP_NODE 0 DIODE_LED
.MODEL DIODE_LED D(IS=1E-18 N=1.8 RS=5)

* -----------------------------------------------------------------------------
* SIMULATION COMMANDS
* -----------------------------------------------------------------------------
.TRAN 0.01 20.0
.PROBE
.END
